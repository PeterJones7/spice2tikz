* Resistive voltage divider
V1 in 0 DC 5
R1 in mid 10k
R2 mid 0 10k
.op
.end
