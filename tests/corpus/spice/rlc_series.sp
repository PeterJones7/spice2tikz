* Series RLC network
V1 in 0 SIN(0 1 1k)
R1 in mid 100
L1 mid vc 10m
C1 vc 0 100n
.tran 1u 5m
.end
