* Controlled source showcase (E/F/G/H)
V1 in 0 AC 1
R1 in 0 1k
E1 amp 0 in 0 10
R2 amp sense 100
VS sense 0 DC 0
G1 gm 0 in 0 1m
R3 gm 0 1k
H1 hout 0 VS 50
R4 hout 0 1k
F1 0 fout VS 2
R5 fout 0 1k
.ac dec 10 1 1meg
.end
